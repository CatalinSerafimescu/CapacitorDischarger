* 600V Capacitor Discharger — transient simulation
* Template placeholders: NAME V0 CDUT TSTEP TSTOP DUT IC (double-brace form)
* Generated by run_sim.py — do not edit directly.
.include E:/Catalin/Work/Electronics/CapacitorDischarger_Claude/simulation/models.lib
.param V0=8 CDUT=1.000000e-04

* ── DUT between the probes (default: capacitor with IC={V0}) ─
* Scenarios may override the DUT placeholder (hot-plug contact, live supply).
C_dut n_probe_a n_probe_b {CDUT} IC={V0}

* ── Reverse-polarity bridge (D1-D4) between probes and HVp/0 ─
D1      n_probe_a HVp        D1N4007
D3      n_probe_b HVp        D1N4007
D4      0         n_probe_a  D1N4007
D2      0         n_probe_b  D1N4007

* ── Slow path: 5 × 4.7 kΩ in series ────────────────────────
* V_islow is a 0 V ammeter placed at the branch head
V_islow HVp n_slow1 0
R_slow1 n_slow1 n_slow2 4.7k
R_slow2 n_slow2 n_slow3 4.7k
R_slow3 n_slow3 n_slow4 4.7k
R_slow4 n_slow4 n_slow5 4.7k
R_slow5 n_slow5 0       4.7k

* ── Fast path: R_fast → Q2 (MOSFET) drain→source→GND ───────
V_ifast HVp n_rfast 0
R_fast  n_rfast n_tf1 50
S_TF1   n_tf1 n_drain 0 n_tf_latch SWTCO
M_Q2    n_drain n_gate 0 0 STP10NK80Z

* TF1 thermal cutoff (SEFUSE SF129R0, Tf = 133 °C, Th ≈ 118 °C) clamped to
* the R_fast body. Behavioural thermal model, node voltage = °C:
* R_fast power heats C_th (3 J/K, ASSUMED body+TCO heat capacity) which
* leaks to 25 °C ambient through R_th (25 K/W, ASSUMED body-surface rise).
* Once T > 133 °C the latch charges and S_TF1 opens permanently (one-shot).
B_pfast 0 n_temp I = I(V_ifast)*I(V_ifast)*50
C_th    n_temp 0 3
R_th    n_temp n_amb 25
V_amb   n_amb 0 25
B_tf    0 n_tf_latch I = V(n_temp) > 133 ? 1 : 0
C_tf    n_tf_latch 0 1m
R_tf    n_tf_latch 0 1G

* Gate drive: R5 pull-up from HVp, D9 clamps to 12 V
* Q1 NPN: saturates above ~63 V → pulls n_gate_top low → Q2 off
R5      HVp n_gate_top 470k
D_D9    0   n_gate_top DZ12
R4      n_gate_top n_gate 100
C_byp2  n_gate 0 100n

* Q1 base divider: R1 (1 MΩ) / R2 (10 kΩ), R3 = 10 kΩ → threshold ≈ 63 V
R1      HVp n_base_top 1Meg
R2      n_base_top 0   10k
R3      n_base_top n_q1b 10k
Q1      n_gate_top n_q1b 0 QMPSA42

* ── LED danger indicator (cutoff ≈ 10.2 V) ──────────────────
* OFF below V_Z(8.2V) + Vf(2V) = 10.2 V
V_iled  HVp n_led1 0
R_LED1  n_led1 n_led2 100k
R_LED2  n_led2 n_led3 100k
R_LED3  n_led3 n_led4 100k
R_LED4  n_led4 n_dled 100k
D_DLED  n_led_a n_dled DZ8V2
D_LED1  n_led_a 0      DLED

* ── DVM signal divider 10 000:1 (600 V → 60 mV, PM-128 reads "600") ─
* D_clamp limits n_sigout to ~0.7 V if R_sigb opens; R_dvm = PM-128 input (>100 MΩ)
V_isig  HVp n_sig1 0
R_sig1  n_sig1 n_sig2 100k
R_sig2  n_sig2 n_sig3 100k
R_sig3  n_sig3 n_sig4 100k
R_sig4  n_sig4 n_sig5 100k
R_sig5  n_sig5 n_sigout 100k
R_sigb1 n_sigout 0 100
R_sigb2 n_sigout 0 100
D_clamp n_sigout 0 D1N4007
R_dvm   n_sigout 0 100Meg

* DVM Vcc branch removed 2026-07-29: the DVM module (measured 12-15 mA)
* is now powered by an internal 9 V battery, not from the HV rail.

* ── Initial conditions ───────────────────────────────────────
* Default IC placeholder: V(HVp) is approximated one diode drop below |V0| so the
* bridge doesn't see a near-instant 600V step at t=0 (avoids "timestep too
* small"); max() puts V0 on whichever probe is positive (reverse polarity).
.ic V(n_probe_a)={max(V0,0)} V(n_probe_b)={max(-V0,0)} V(HVp)={abs(V0)-0.7}
.ic V(n_temp)=25 V(n_tf_latch)=0

* ── Transient analysis ───────────────────────────────────────
.tran 1m 2 uic

* ── Save variables ───────────────────────────────────────────
.save V(HVp) V(n_gate) V(n_gate_top) V(n_sigout) V(n_led_a) V(n_probe_a) V(n_probe_b) V(n_temp) V(n_tf_latch)
.save I(V_islow) I(V_ifast) I(V_iled) I(V_isig)

* ── Run and export ───────────────────────────────────────────
.control
run
wrdata E:/Catalin/Work/Electronics/CapacitorDischarger_Claude/simulation/results/E_below_LED_8V_100uF/out.csv V(HVp) V(n_gate) V(n_gate_top) V(n_sigout) V(n_led_a) V(n_probe_a) V(n_probe_b) I(V_islow) I(V_ifast) I(V_iled) I(V_isig) V(n_temp) V(n_tf_latch)
quit
.endc

.end
