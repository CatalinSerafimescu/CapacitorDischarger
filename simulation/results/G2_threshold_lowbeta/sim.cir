* 600V Capacitor Discharger — DC sweep (scenario G2: worst-case low-hFE threshold)
* Template placeholders: G2_threshold_lowbeta E:/Catalin/Work/Electronics/CapacitorDischarger_Claude/simulation/results/G2_threshold_lowbeta/out.csv
* V_HVp sweeps 0→200 V; Q1 uses QMPSA42LB (BF=40) worst-case corner —
* confirms gate logic still flips at a safe voltage even with low-hFE parts
.include E:/Catalin/Work/Electronics/CapacitorDischarger_Claude/simulation/models.lib

* ── Stimulus: voltage source sweeping HVp ───────────────────
V_HVp HVp 0 0

* ── Slow path (passive, loads HVp for accuracy) ─────────────
R_slow1 HVp n_slow2 4.7k
R_slow2 n_slow2 n_slow3 4.7k
R_slow3 n_slow3 n_slow4 4.7k
R_slow4 n_slow4 n_slow5 4.7k
R_slow5 n_slow5 0       4.7k

* ── Gate drive ───────────────────────────────────────────────
R5      HVp n_gate_top 470k
D_D9    0   n_gate_top DZ12
R4      n_gate_top n_gate 100
C_byp2  n_gate 0 100n

* ── Q1 threshold detector (worst-case low-hFE, BF=40) ────────
R1      HVp n_base_top 1Meg
R2      n_base_top 0   10k
R3      n_base_top n_q1b 10k
Q1      n_gate_top n_q1b 0 QMPSA42LB

* ── Fast path MOSFET (drain to separate load for I readout) ──
R_fast  HVp n_drain 50
M_Q2    n_drain n_gate 0 0 STP10NK80Z

* ── LED chain ────────────────────────────────────────────────
R_LED1  HVp n_led2 100k
R_LED2  n_led2 n_led3 100k
R_LED3  n_led3 n_led4 100k
R_LED4  n_led4 n_dled 100k
D_DLED  n_led_a n_dled DZ8V2
D_LED1  n_led_a 0      DLED
D_clamp2 0 n_led_a    DZ8V2

* ── DVM signal divider 10 000:1 + clamp + PM-128 input ───────
R_sig1  HVp n_sig2 100k
R_sig2  n_sig2 n_sig3 100k
R_sig3  n_sig3 n_sig4 100k
R_sig4  n_sig4 n_sig5 100k
R_sig5  n_sig5 n_sigout 100k
R_sigb1 n_sigout 0 100
R_sigb2 n_sigout 0 100
D_clamp n_sigout 0 D1N4007
R_dvm   n_sigout 0 100Meg

* DVM Vcc branch removed 2026-07-29: DVM is powered by an internal 9 V battery.

* ── DC sweep ─────────────────────────────────────────────────
.dc V_HVp 0 200 0.5

.save V(HVp) V(n_gate) V(n_gate_top) V(n_sigout) V(n_led_a)

.control
run
wrdata E:/Catalin/Work/Electronics/CapacitorDischarger_Claude/simulation/results/G2_threshold_lowbeta/out.csv V(HVp) V(n_gate) V(n_gate_top) V(n_sigout) V(n_led_a)
quit
.endc

.end
