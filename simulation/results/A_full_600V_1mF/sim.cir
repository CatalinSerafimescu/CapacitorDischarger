* 600V Capacitor Discharger — transient simulation
* Template placeholders: A_full_600V_1mF 600 1.000000e-03 10m 120
* Generated by run_sim.py — do not edit directly.
.include E:/Catalin/Work/Electronics/CapacitorDischarger_Claude/simulation/models.lib
.param V0=600 CDUT=1.000000e-03

* ── DUT capacitor with initial condition ─────────────────────
C_dut n_probe_a n_probe_b {CDUT} IC={V0}

* ── Reverse-polarity bridge (D1-D4) between probes and HVp/0 ─
D1      n_probe_a HVp        D1N4007
D3      n_probe_b HVp        D1N4007
D4      0         n_probe_a  D1N4007
D2      0         n_probe_b  D1N4007

* ── Slow path: 5 × 4.7 kΩ in series ────────────────────────
* V_islow is a 0 V ammeter placed at the branch head
V_islow HVp n_slow1 0
R_slow1 n_slow1 n_slow2 4.7k
R_slow2 n_slow2 n_slow3 4.7k
R_slow3 n_slow3 n_slow4 4.7k
R_slow4 n_slow4 n_slow5 4.7k
R_slow5 n_slow5 0       4.7k

* ── Fast path: R_fast → Q2 (MOSFET) drain→source→GND ───────
V_ifast HVp n_rfast 0
R_fast  n_rfast n_drain 50
M_Q2    n_drain n_gate 0 0 STP10NK80Z

* Gate drive: R5 pull-up from HVp, D9 clamps to 12 V
* Q1 NPN: saturates above ~63 V → pulls n_gate_top low → Q2 off
R5      HVp n_gate_top 470k
D_D9    0   n_gate_top DZ12
R4      n_gate_top n_gate 100
C_byp2  n_gate 0 100n

* Q1 base divider: R1 (1 MΩ) / R2 (10 kΩ), R3 = 10 kΩ → threshold ≈ 63 V
R1      HVp n_base_top 1Meg
R2      n_base_top 0   10k
R3      n_base_top n_q1b 10k
Q1      n_gate_top n_q1b 0 QMPSA42

* ── LED danger indicator (cutoff ≈ 10.2 V) ──────────────────
* OFF below V_Z(8.2V) + Vf(2V) = 10.2 V
V_iled  HVp n_led1 0
R_LED1  n_led1 n_led2 100k
R_LED2  n_led2 n_led3 100k
R_LED3  n_led3 n_led4 100k
R_LED4  n_led4 n_dled 100k
D_DLED  n_led_a n_dled DZ8V2
D_LED1  n_led_a 0      DLED

* ── DVM signal divider 6:1 (0–600 V → 0–100 V) ─────────────
V_isig  HVp n_sig1 0
R_sig1  n_sig1 n_sig2 100k
R_sig2  n_sig2 n_sig3 100k
R_sig3  n_sig3 n_sig4 100k
R_sig4  n_sig4 n_sig5 100k
R_sig5  n_sig5 n_sigout 100k
R_sigb  n_sigout n_rcal 100k
R_cal   n_rcal 0       1

* DVM Vcc branch removed 2026-07-29: the DVM module (measured 12-15 mA)
* is now powered by an internal 9 V battery, not from the HV rail.

* ── Initial conditions ───────────────────────────────────────
* V(HVp) is approximated one diode drop below V0 so the bridge diode D1
* doesn't see a near-instant 600V step at t=0 (avoids "timestep too small").
.ic V(n_probe_a)={V0} V(n_probe_b)=0 V(HVp)={V0-0.7}

* ── Transient analysis ───────────────────────────────────────
.tran 10m 120 uic

* ── Save variables ───────────────────────────────────────────
.save V(HVp) V(n_gate) V(n_gate_top) V(n_sigout) V(n_led_a) V(n_probe_a) V(n_probe_b)
.save I(V_islow) I(V_ifast) I(V_iled) I(V_isig)

* ── Run and export ───────────────────────────────────────────
.control
run
wrdata E:/Catalin/Work/Electronics/CapacitorDischarger_Claude/simulation/results/A_full_600V_1mF/out.csv V(HVp) V(n_gate) V(n_gate_top) V(n_sigout) V(n_led_a) V(n_probe_a) V(n_probe_b) I(V_islow) I(V_ifast) I(V_iled) I(V_isig)
quit
.endc

.end
